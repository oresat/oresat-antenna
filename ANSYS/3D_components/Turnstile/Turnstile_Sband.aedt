# Ansys Electronics Desktop project, version 2018.1
materials:
  vacuum: permittivity=1
  copper: permeability=0.999991 conductivity=58000000
  Astroquartz: permittivity=3.72 delta_H_freq=1000000000
  FR4_epoxy: permittivity=4.4 dielectric_loss_tangent=0.02

design HFSSDesign1 (HFSS, DrivenTerminal, model units mm)
options: open_region{BoundaryType=0 OpFreq=2422MHz}
variables:
  Ant_diameter = 2mm
  UHF_len = 172mm
  UHF_x = 30.13mm
  UHF_y = 27.34mm
  zPlane = -10mm
  Ant_Phi = 45deg
  Ant_Theta = 0deg
  Ant_lead = 1mm
  Lband_x = -0.65mm
  Lband_y = -4.19mm
  Lband_len = 59mm
  Sband_x = -0.65mm
  Sband_y = 4.19mm
  Sband_len = 31mm
  Snap_width = 18mm
  Snap_radius = -(Lband_x^2+Lband_y^2)/(2*Lband_x) meter
  Snap_angle = Snap_width/Snap_radius rad
  Snap_laminant = 0.25mm
  zC = 0
  p = 0
geometry:
  RadiatingSurface [vacuum] = region(absolute_offset=41.288192mm on all sides)
  coordinate_system UHF_Ant = origin=(UHF_x, UHF_y, zPlane+Ant_lead) x=(1mm, 0mm, 0mm) y=(0mm, 1mm, 0mm)
  UHF [copper, oriented by UHF_Ant] = cylinder(axis=Z, base_centre=(0, 0, 0), radius=Ant_diameter/2, height=UHF_len) in UHF_Ant
  UHF.rotate(axis=Y, angle=Ant_Phi) in UHF_Ant
  UHF.rotate(axis=Z, angle=Ant_Theta) in UHF_Ant
  coordinate_system L_Band_Ant = origin=(Lband_x, Lband_y, 0mm) x=(1mm, 0mm, 0mm) y=(0mm, 1mm, 0mm) in UHF_Ant
  L_Band [copper, oriented by L_Band_Ant] = cylinder(axis=Z, base_centre=(0, 0, 0), radius=Ant_diameter/2, height=Lband_len) in L_Band_Ant
  coordinate_system S_Band_Ant = origin=(Sband_x, Sband_y, 0mm) x=(1mm, 0mm, 0mm) y=(0mm, 1mm, 0mm) in UHF_Ant
  S_Band [copper] = cylinder(axis=Z, base_centre=(0mm, 0mm, 0mm), radius=Ant_diameter/2, height=Sband_len) in S_Band_Ant
  L_Band.rotate(axis=Y, angle=Ant_Phi) in L_Band_Ant
  L_Band.rotate(axis=Z, angle=Ant_Theta) in UHF_Ant
  S_Band.rotate(axis=Y, angle=Ant_Phi) in S_Band_Ant
  S_Band.rotate(axis=Z, angle=Ant_Theta) in UHF_Ant
  Snap_Band_Form [Astroquartz, oriented by UHF_Ant] = equation_based_surface(XuvFunction=-(Snap_radius-(_u*cos(_v))) YuvFunction=-(_u*cos(Ant_Phi)+Snap_radius*(1-cos(Ant_Phi)))*sin(_v) ZuvFunction=0 uStart=Snap_radius-Ant_diameter/(2*cos(Ant_Phi))-Snap_laminant/sin(Ant_Phi) uEnd=Snap_radius+Ant_diameter/(2*cos(Ant_Phi))+Snap_laminant/sin(Ant_Phi) vStart=Snap_angle/2 vEnd=-Snap_angle/2) in UHF_Ant
  Snap_Band_Length = polyline((0mm, 0mm, 0mm) (0mm, 0mm, 200mm)) in UHF_Ant
  Snap_Band_Length.rotate(axis=Y, angle=Ant_Phi) in UHF_Ant
  Snap_Band_Form.sweep_along_path(Snap_Band_Length)
  Snap_Band_Form.rotate(axis=Z, angle=Ant_Theta) in UHF_Ant
  Antenna_Cut = object_from(Snap_Band_Form.face(1 of 1))
  Polyline2 = polyline((0mm, 0mm, 0mm) (0mm, 0mm, -3/5*Ant_diameter*sin(Ant_Phi))) in UHF_Ant
  Antenna_Cut.sweep_along_path(Polyline2)
  Antenna_Cut.rotate(axis=Z, angle=Ant_Theta) in UHF_Ant
  Antenna_Cut_1 = Antenna_Cut.copy()
  L_Band.subtract(Antenna_Cut_1)
  Antenna_Cut_2 = Antenna_Cut.copy()
  S_Band.subtract(Antenna_Cut_2)
  UHF.subtract(Antenna_Cut)
  L_Band_1 = L_Band.copy()
  S_Band_1 = S_Band.copy()
  UHF_1 = UHF.copy()
  Snap_Band_Form.subtract(L_Band_1, S_Band_1, UHF_1)
  UHF_pin = cylinder(axis=Z, base_centre=(0mm, 0mm, 0mm), radius=Ant_diameter/2, height=-Ant_lead) in UHF_Ant
  Lband_pin = cylinder(axis=Z, base_centre=(0mm, 0mm, 0mm), radius=Ant_diameter/2, height=-Ant_lead) in L_Band_Ant
  Lband_pin.rotate(axis=Z, angle=Ant_Theta) in UHF_Ant
  Sband_pin = rectangle(corner=(0mm, Ant_diameter/2, 0mm), y_size=-Ant_diameter, z_size=-Ant_lead) in S_Band_Ant
  L_Band.unite(Lband_pin)
  Sband_pin.rotate(axis=Z, angle=Ant_Theta) in UHF_Ant
  UHF.unite(UHF_pin)
  Layer1 [copper] = box(corner=(-44.8mm, -49.9mm, -10mm-zC*10mm+p*1.641mm), size=(94.7mm, 99.8mm, -0.0356mm))
  cornerCut1 = box(corner=(49.9mm, 49.9mm, -10mm-zC*10mm+p*1.641mm), size=(-8.5mm, -15.5mm, -1.641mm))
  corner1 = box(corner=(41.4mm, 34.4mm, -10mm-zC*10mm+p*1.641mm), size=(4.9mm, 12.75mm, -1.641mm))
  cornerCut1.subtract(corner1)
  cornerCut1_1 = cornerCut1.copy()
  cornerCut1_2 = cornerCut1.copy()
  cornerCut1_3 = cornerCut1.copy()
  cornerCut1_4 = cornerCut1.copy()
  cornerCut2 = box(corner=(49.9mm, -49.9mm, -10mm-zC*10mm+p*1.641mm), size=(-8.5mm, 15.5mm, -1.641mm))
  corner2 = box(corner=(41.4mm, -34.4mm, -10mm-zC*10mm+p*1.641mm), size=(4.9mm, -12.75mm, -1.641mm))
  cornerCut2.subtract(corner2)
  cornerCut2_1 = cornerCut2.copy()
  cornerCut2_2 = cornerCut2.copy()
  cornerCut2_3 = cornerCut2.copy()
  cornerCut2_4 = cornerCut2.copy()
  Layer1.subtract(cornerCut1_4, cornerCut2_4)
  Layer1.chamfer(Edges=Layer1.edge(11 of 12, 9 of 12) LeftDistance=5.8mm RightDistance=5.8mm ChamferType=Symmetric)
  insulator1 [FR4_epoxy] = box(corner=(-44.8mm, -49.9mm, -10.0356mm-zC*10mm+p*1.641mm), size=(94.7mm, 99.8mm, -0.1702mm))
  insulator1.subtract(cornerCut1_1, cornerCut2_1)
  insulator1.chamfer(Edges=insulator1.edge(11 of 12, 9 of 12) LeftDistance=5.8mm RightDistance=5.8mm ChamferType=Symmetric)
  Layer15 [copper] = box(corner=(-44.8mm, -49.9mm, -10.2058mm-zC*10mm+p*1.641mm), size=(94.7mm, 99.8mm, -0.0178mm))
  cornerCut1_5 = cornerCut1.copy()
  cornerCut2_5 = cornerCut2.copy()
  Layer15.subtract(cornerCut1_5, cornerCut2_5)
  Layer15.chamfer(Edges=Layer15.edge(11 of 12, 9 of 12) LeftDistance=5.8mm RightDistance=5.8mm ChamferType=Symmetric)
  insulator2 [FR4_epoxy] = box(corner=(-44.8mm, -49.9mm, -10.2236mm-zC*10mm+p*1.641mm), size=(94.7mm, 99.8mm, -1.1938mm))
  insulator2.subtract(cornerCut1_2, cornerCut2_2)
  insulator2.chamfer(Edges=insulator2.edge(11 of 12, 9 of 12) LeftDistance=5.8mm RightDistance=5.8mm ChamferType=Symmetric)
  Layer16 [copper] = box(corner=(-44.8mm, -49.9mm, -11.4174mm-zC*10mm+p*1.641mm), size=(94.7mm, 99.8mm, -0.0178mm))
  cornerCut1_6 = cornerCut1.copy()
  cornerCut2_6 = cornerCut2.copy()
  Layer16.subtract(cornerCut1_6, cornerCut2_6)
  Layer16.chamfer(Edges=Layer16.edge(11 of 12, 9 of 12) LeftDistance=5.8mm RightDistance=5.8mm ChamferType=Symmetric)
  insulator3 [FR4_epoxy] = box(corner=(-44.8mm, -49.9mm, -11.4352mm-zC*10mm+p*1.641mm), size=(94.7mm, 99.8mm, -0.1702mm))
  insulator3.subtract(cornerCut1_3, cornerCut2_3)
  insulator3.chamfer(Edges=insulator3.edge(11 of 12, 9 of 12) LeftDistance=5.8mm RightDistance=5.8mm ChamferType=Symmetric)
  Layer2 [copper] = box(corner=(-44.8mm, -49.9mm, -11.6054mm-zC*10mm+p*1.641mm), size=(94.7mm, 99.8mm, -0.0356mm))
  Layer2.subtract(cornerCut1, cornerCut2)
  Layer2.chamfer(Edges=Layer2.edge(11 of 12, 9 of 12) LeftDistance=5.8mm RightDistance=5.8mm ChamferType=Symmetric)
  UHF_2, UHF_3, UHF_4 [copper, oriented by UHF_Ant] = UHF.duplicate_around_axis(axis=Z, angle=90deg, total=4)
  L_Band_2, L_Band_3, L_Band_4 [copper, oriented by L_Band_Ant] = L_Band.duplicate_around_axis(axis=Z, angle=90deg, total=4)
  S_Band_2, S_Band_3, S_Band_4 [copper] = S_Band.duplicate_around_axis(axis=Z, angle=90deg, total=4)
  Snap_Band_Form_1, Snap_Band_Form_2, Snap_Band_Form_3 [Astroquartz, oriented by UHF_Ant] = Snap_Band_Form.duplicate_around_axis(axis=Z, angle=90deg, total=4)
  Sband_pin_1, Sband_pin_2, Sband_pin_3 = Sband_pin.duplicate_around_axis(axis=Z, angle=90deg, total=4)
boundaries and excitations:
  AutoOpen1: Radiation Objects=RadiatingSurface
  S_Band_T1: Terminal port=1 Edges=S_Band.edge(at (29.48, 31.53, -9)) TerminalResistance=50ohm
  S_Band_2_T1: Terminal port=2 Edges=S_Band_2.edge(2 of 4) TerminalResistance=50ohm
  S_Band_3_T1: Terminal port=3 Edges=S_Band_3.edge(2 of 4) TerminalResistance=50ohm
  S_Band_4_T1: Terminal port=4 Edges=S_Band_4.edge(2 of 4) TerminalResistance=50ohm
  1: Lumped Port Faces=Sband_pin.face(#373) Impedance=50ohm
  2: Lumped Port Faces=Sband_pin_1.face Impedance=50ohm
  3: Lumped Port Faces=Sband_pin_2.face Impedance=50ohm
  4: Lumped Port Faces=Sband_pin_3.face Impedance=50ohm
  reference conductors: Layer1
setups:
  Sband: HfssDriven Frequency=2422MHz MaxDeltaS=0.05 MaximumPasses=30 MinimumPasses=1 MinimumConvergedPasses=1 PercentRefinement=30 BasisOrder=1 PortAccuracy=2 IterativeResidual=1e-06 DDMSolverResidual=0.0001
source amplitudes:
  1:1: 1V 0deg
  2:1, 3:1, 4:1: 0V 0deg
radiation setups:
  3D: Infinite Sphere Theta=0deg..180deg step 2deg Phi=-180deg..180deg step 2deg
  Elevation: Infinite Sphere Theta=-180deg..180deg step 1deg Phi=0deg..90deg step 90deg
  Azimuth: Infinite Sphere Theta=90deg..90deg step 0deg Phi=-180deg..180deg step 1deg
reports:
  Terminal S Parameter Chart 1: ; markers m1 at 0.436GHz
  Terminal S Parameter Plot 1: ; markers m1 at 0.41GHz
  3D RHCP Gain (bottom): dB(GainRHCP) vs Phi, Theta on Sband : LastAdaptive, 3D [Freq=all]
  3D LHCP Gain (top): dB(GainLHCP) vs Phi, Theta on Sband : LastAdaptive, 3D [Freq=all]
  Elevation Gain LHCP (dBiC): dB(GainLHCP) vs Theta on Sband : LastAdaptive, Elevation [Phi=all Freq=all]; markers m1 at 180deg
  Elevation Gain RHCP (primary) (dBiC): dB(GainRHCP) vs Theta on Sband : LastAdaptive, Elevation [Phi=all Freq=all]; markers m1 at 0deg, m2 at 0deg, m3 at -18deg, m4 at 17deg
