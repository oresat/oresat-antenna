# Ansys Electronics Desktop project, version 2018.1
materials:
  vacuum: permittivity=1
  pec: conductivity=1e+30

design HFSSDesign1 (HFSS, DrivenTerminal, model units mm)
options: Calculate_Lossy_Dielectrics open_region{BoundaryType=0 OpFreq=436MHz}
variables:
  CubeXY = 10cm
  CubeZ = 20cm
  Ant_height = 2mm
  AntX = 30mm
  AntY = 30mm
  Ant_rotateX = 45deg
  Ant_rotateZ = 45deg
  Ant_diameter = 2mm
  Ant_lengthB = 172mm
  Ant_lengthA = 172mm
geometry:
  Cube [pec] = box(corner=(-CubeXY/2, -CubeXY/2, 0mm), size=(CubeXY, CubeXY, -CubeZ))
  Element [pec] = cylinder(axis=Z, base_centre=(AntX, AntY, Ant_height), radius=Ant_diameter / 2, height=Ant_lengthA)
  coordinate_system FaceCS1 = face of Element: Origin=Element.edge(1 of 2) FaceID=Element.face(2 of 3) AxisPosn=middle of Element.edge(1 of 2) WhichAxis=X
  Element.rotate(axis=X, angle=Ant_rotateX) in FaceCS1
  Cut_Ends [pec, non-model] = object_from(Cube.face(+z))
  Cut_Ends.move(0mm, 0mm, Ant_height)
  Element.split(plane=Cube_ObjectFromFace1_1.face, keep=NegativeOnly)
  Cube_ObjectFromFace1_1 = Cut_Ends.copy()
  Cube_ObjectFromFace1_1.delete()
  Element.rotate(axis=Z, angle=Ant_rotateZ) in FaceCS1
  Field = rectangle(corner=(Ant_diameter / 2, 0mm, 0mm), z_size=Ant_height, x_size=-Ant_diameter) in FaceCS1
  Field.rotate(axis=Z, angle=Ant_rotateZ) in FaceCS1
  Element1 [pec] = cylinder(axis=Z, base_centre=(AntX, AntY, Ant_height), radius=Ant_diameter / 2, height=Ant_lengthB)
  Element1.rotate(axis=X, angle=Ant_rotateX) in FaceCS2
  Element1.split(plane=Cube_ObjectFromFace1_2.face, keep=NegativeOnly)
  Element1.rotate(axis=Z, angle=Ant_rotateZ) in FaceCS2
  Cube1 = box(corner=(-CubeXY/2, -CubeXY/2, 0mm), size=(CubeXY, CubeXY, -CubeZ))
  Cube_ObjectFromFace2 = object_from(Cube1.face(+z))
  Cube1.delete()
  Cube_ObjectFromFace2.move(0mm, 0mm, Ant_height)
  Cube_ObjectFromFace1_2 = Cube_ObjectFromFace2.copy()
  [Cube_ObjectFromFace2, Cube_ObjectFromFace1_2].delete()
  coordinate_system FaceCS2 = face of Element1: Origin=Element1.edge(1 of 2) FaceID=Element1.face(2 of 3) AxisPosn=middle of Element1.edge(1 of 2) WhichAxis=X
  Element1.rotate(axis=Z, angle=90deg)
  Element_1 [pec] = Element.duplicate_around_axis(axis=Z, angle=180deg, total=2)
  Element1_1 [pec] = Element1.duplicate_around_axis(axis=Z, angle=180deg, total=2)
  Field_1, Field_2, Field_3 = Field.duplicate_around_axis(axis=Z, angle=90deg, total=4)
  RadiatingSurface [vacuum] = region(absolute_offset=229.3578mm on all sides)
boundaries and excitations:
  Ground: Perfect E Objects=Cube
  AutoOpen1: Radiation Objects=RadiatingSurface
  port1: Terminal port=1 Edges=Element.edge(#130) TerminalResistance=50ohm
  port2: Terminal port=2 Edges=Element1.edge(#222) TerminalResistance=50ohm
  port3: Terminal port=3 Edges=Element_1.edge(2 of 4) TerminalResistance=50ohm
  port4: Terminal port=4 Edges=Element1_1.edge(2 of 4) TerminalResistance=50ohm
  1: Lumped Port Faces=Field.face(#127) Impedance=50ohm
  2: Lumped Port Faces=Field_1.face Impedance=50ohm
  3: Lumped Port Faces=Field_2.face Impedance=50ohm
  4: Lumped Port Faces=Field_3.face Impedance=50ohm
  reference conductors: Cube
mesh:
  initial mesh: GlobalSurfApproximation{CurvedSurfaceApproxChoice=UseSlider SliderMeshSettings=2}
setups:
  Setup1: HfssDriven Frequency=436MHz MaxDeltaS=0.05 MaximumPasses=30 MinimumPasses=1 MinimumConvergedPasses=1 PercentRefinement=30 BasisOrder=1 PortAccuracy=2 IterativeResidual=1e-06 DDMSolverResidual=0.0001
    sweep Sweep: 396MHz to 476MHz step 5MHz; Type=Interpolating InterpTolerance=0.5 InterpMaxSolns=999 PassivityErrorTolerance=0.0001
source amplitudes:
  1:1: 1V 0deg
  2:1: 1V 90deg
  3:1: 1V 180deg
  4:1: 1V 270deg
radiation setups:
  3D: Infinite Sphere Theta=0deg..180deg step 2deg Phi=-180deg..180deg step 2deg
  Elevation: Infinite Sphere Theta=-180deg..180deg step 1deg Phi=0deg..90deg step 90deg
  Azimuth: Infinite Sphere Theta=90deg..90deg step 0deg Phi=-180deg..180deg step 1deg
reports:
  Terminal S Parameter Chart 1: St(port1,port1) on Setup1 : Sweep [Freq=all Ant_rotateX=all]; markers m1 at 0.436GHz
  Terminal S Parameter Plot 1: dB(St(port1,port1)) vs Freq on Setup1 : Sweep [Ant_rotateX=all]; markers m1 at 0.406GHz
  3D RHCP Gain (bottom): dB(GainRHCP) vs Phi, Theta on Setup1 : LastAdaptive, 3D [Freq=0.436GHz]
  3D LHCP Gain (top): dB(GainLHCP) vs Phi, Theta on Setup1 : LastAdaptive, 3D [Freq=0.436GHz]
