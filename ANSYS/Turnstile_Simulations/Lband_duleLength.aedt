# Ansys Electronics Desktop project, version 2018.1
materials:
  vacuum: permittivity=1
  copper: permeability=0.999991 conductivity=58000000
  Astroquartz: permittivity=3.72 delta_H_freq=1000000000
  FR4_epoxy: permittivity=4.4 dielectric_loss_tangent=0.02

design HFSSDesign1 (HFSS, DrivenTerminal, model units mm)
options: open_region{BoundaryType=0 OpFreq=1265MHz}
variables:
  Ant_diameter = 2mm
  UHF_len = 172mm
  UHF_x = 30mm
  UHF_y = 29mm
  zPlane = -10mm
  Ant_Phi = 45deg
  Ant_Theta = 0deg
  Ant_lead = 1mm
  Lband_x = -0.65mm
  Lband_y = -4.19mm
  Lband_len = 59mm
  Sband_x = -0.65mm
  Sband_y = 4.19mm
  Sband_len = 31mm
  Snap_width = 18mm
  Snap_radius = -(Lband_x^2+Lband_y^2)/(2*Lband_x) meter
  Snap_angle = Snap_width/Snap_radius rad
  Snap_laminant = 0.25mm
  Snap_len = 200mm
  UHF_len_a = 172mm
  Sband_len_a = 31mm
  Lband_len_a = 59mm
  Lband_len_b = 59mm
  Sband_len_b = 31mm
  UHF_len_b = 172mm
  zC = 0
  p = 0
geometry:
  RadiatingSurface [vacuum] = region(absolute_offset=79.051383mm on all sides)
  coordinate_system UHF_Ant_a = origin=(UHF_x, UHF_y, zPlane+Ant_lead) x=(1mm, 0mm, 0mm) y=(0mm, 1mm, 0mm)
  UHF_a [copper, oriented by UHF_Ant_a] = cylinder(axis=Z, base_centre=(0, 0, 0), radius=Ant_diameter/2, height=UHF_len_a) in UHF_Ant_a
  UHF_a.rotate(axis=Y, angle=Ant_Phi) in UHF_Ant_a
  UHF_a.rotate(axis=Z, angle=Ant_Theta) in UHF_Ant_a
  coordinate_system L_Band_Ant_a = origin=(Lband_x, Lband_y, 0mm) x=(1mm, 0mm, 0mm) y=(0mm, 1mm, 0mm) in UHF_Ant_a
  L_Band_a [copper, oriented by L_Band_Ant_a] = cylinder(axis=Z, base_centre=(0, 0, 0), radius=Ant_diameter/2, height=Lband_len_a) in L_Band_Ant_a
  coordinate_system S_Band_Ant_a = origin=(Lband_x, -Lband_y, 0mm) x=(1mm, 0mm, 0mm) y=(0mm, 1mm, 0mm) in UHF_Ant_a
  S_Band_a [copper] = cylinder(axis=Z, base_centre=(0mm, 0mm, 0mm), radius=Ant_diameter/2, height=Sband_len_a) in S_Band_Ant_a
  L_Band_a.rotate(axis=Y, angle=Ant_Phi) in L_Band_Ant_a
  L_Band_a.rotate(axis=Z, angle=Ant_Theta) in UHF_Ant_a
  S_Band_a.rotate(axis=Y, angle=Ant_Phi) in S_Band_Ant_a
  S_Band_a.rotate(axis=Z, angle=Ant_Theta) in UHF_Ant_a
  Snap_Band_Form_a [Astroquartz, oriented by UHF_Ant_a] = equation_based_surface(XuvFunction=-(Snap_radius-(_u*cos(_v))) YuvFunction=-(_u*cos(Ant_Phi)+Snap_radius*(1-cos(Ant_Phi)))*sin(_v) ZuvFunction=0 uStart=Snap_radius-Ant_diameter/(2*cos(Ant_Phi))-Snap_laminant/sin(Ant_Phi) uEnd=Snap_radius+Ant_diameter/(2*cos(Ant_Phi))+Snap_laminant/sin(Ant_Phi) vStart=Snap_angle/2 vEnd=-Snap_angle/2) in UHF_Ant_a
  Snap_Band_Length = polyline((0mm, 0mm, 0mm) (0mm, 0mm, Snap_len)) in UHF_Ant_a
  Snap_Band_Length.rotate(axis=Y, angle=Ant_Phi) in UHF_Ant_a
  Snap_Band_Form_a.sweep_along_path(Snap_Band_Length)
  Snap_Band_Form_a.rotate(axis=Z, angle=Ant_Theta) in UHF_Ant_a
  Antenna_Cut = object_from(Snap_Band_Form_a.face(1 of 1))
  Polyline2 = polyline((0mm, 0mm, 0mm) (0mm, 0mm, -3/5*Ant_diameter*sin(Ant_Phi))) in UHF_Ant_a
  Antenna_Cut.sweep_along_path(Polyline2)
  Antenna_Cut.rotate(axis=Z, angle=Ant_Theta) in UHF_Ant_a
  Ant_Cut_a = Antenna_Cut.copy()
  Antenna_Cut.delete()
  UHF_pin = cylinder(axis=Z, base_centre=(0mm, 0mm, 0mm), radius=Ant_diameter/2, height=-Ant_lead) in UHF_Ant_a
  Sband_pin = cylinder(axis=Z, base_centre=(0mm, 0mm, 0mm), radius=Ant_diameter/2, height=-Ant_lead) in S_Band_Ant_a
  Sband_pin.rotate(axis=Z, angle=Ant_Theta) in UHF_Ant_a
  coordinate_system UHF_Ant_b = origin=(-UHF_y, UHF_x, zPlane+Ant_lead) x=(1mm, 0mm, 0mm) y=(0mm, 1mm, 0mm)
  coordinate_system L_Band_Ant_b = origin=(-Lband_y, Lband_x, 0mm) x=(1mm, 0mm, 0mm) y=(0mm, 1mm, 0mm) in UHF_Ant_b
  coordinate_system S_band_Ant_b = origin=(Lband_y, Lband_x, 0mm) x=(1mm, 0mm, 0mm) y=(0mm, 1mm, 0mm) in UHF_Ant_b
  UHF_b [copper, oriented by UHF_Ant_b] = cylinder(axis=Z, base_centre=(0mm, 0mm, 0mm), radius=Ant_diameter/2, height=UHF_len_b) in UHF_Ant_b
  S_Band_b [copper, oriented by S_band_Ant_b] = cylinder(axis=Z, base_centre=(0mm, 0mm, 0mm), radius=Ant_diameter/2, height=Sband_len_b) in S_band_Ant_b
  L_Band_b [copper, oriented by L_Band_Ant_b] = cylinder(axis=Z, base_centre=(0mm, 0mm, 0mm), radius=Ant_diameter/2, height=Lband_len_b) in L_Band_Ant_b
  UHF_b.rotate(axis=X, angle=-Ant_Phi) in UHF_Ant_b
  S_Band_b.rotate(axis=X, angle=-Ant_Phi) in S_band_Ant_b
  L_Band_b.rotate(axis=X, angle=-Ant_Phi) in L_Band_Ant_b
  [UHF_b, S_Band_b, L_Band_b].rotate(axis=Z, angle=Ant_Theta) in UHF_Ant_b
  Snap_Band_Form_b [Astroquartz, oriented by UHF_Ant_a] = Snap_Band_Form_a.duplicate_around_axis(axis=Z, angle=90deg, total=2)
  Ant_Cut_b = Ant_Cut_a.duplicate_around_axis(axis=Z, angle=90deg, total=2)
  L_Band_a_1 = L_Band_a.copy()
  S_Band_a_1 = S_Band_a.copy()
  UHF_a_1 = UHF_a.copy()
  Snap_Band_Form_a.subtract(L_Band_a_1, S_Band_a_1, UHF_a_1)
  L_Band_b_1 = L_Band_b.copy()
  S_Band_b_1 = S_Band_b.copy()
  UHF_b_1 = UHF_b.copy()
  Snap_Band_Form_b.subtract(L_Band_b_1, S_Band_b_1, UHF_b_1)
  Sband_pin_1 = Sband_pin.duplicate_around_axis(axis=Z, angle=90deg, total=2)
  UHF_pin_1 = UHF_pin.duplicate_around_axis(axis=Z, angle=90deg, total=2)
  Ant_Cut_a_1 = Ant_Cut_a.copy()
  L_Band_a.subtract(Ant_Cut_a_1)
  Ant_Cut_a_2 = Ant_Cut_a.copy()
  S_Band_a.subtract(Ant_Cut_a_2)
  UHF_a.subtract(Ant_Cut_a)
  S_Band_a.unite(Sband_pin)
  UHF_a.unite(UHF_pin)
  Ant_Cut_b_1 = Ant_Cut_b.copy()
  L_Band_b.subtract(Ant_Cut_b_1)
  Ant_Cut_b_2 = Ant_Cut_b.copy()
  S_Band_b.subtract(Ant_Cut_b_2)
  UHF_b.subtract(Ant_Cut_b)
  S_Band_b.unite(Sband_pin_1)
  UHF_b.unite(UHF_pin_1)
  Port_a = rectangle(corner=(0mm, Ant_diameter/2, 0), y_size=-Ant_diameter, z_size=-Ant_lead) in L_Band_Ant_a
  Port_a.rotate(axis=Z, angle=Ant_Theta) in UHF_Ant_a
  Port_b = rectangle(corner=(Ant_diameter/2, 0mm, 0mm), z_size=-Ant_lead, x_size=-Ant_diameter) in L_Band_Ant_b
  Port_b.rotate(axis=Z, angle=Ant_Theta) in UHF_Ant_b
  UHF_a_2 [copper, oriented by UHF_Ant_a] = UHF_a.duplicate_around_axis(axis=Z, angle=180deg, total=2)
  L_Band_a_2 [copper, oriented by L_Band_Ant_a] = L_Band_a.duplicate_around_axis(axis=Z, angle=180deg, total=2)
  S_Band_a_2 [copper] = S_Band_a.duplicate_around_axis(axis=Z, angle=180deg, total=2)
  Snap_Band_Form_a_1 [Astroquartz, oriented by UHF_Ant_a] = Snap_Band_Form_a.duplicate_around_axis(axis=Z, angle=180deg, total=2)
  UHF_b_2 [copper, oriented by UHF_Ant_b] = UHF_b.duplicate_around_axis(axis=Z, angle=180deg, total=2)
  S_Band_b_2 [copper, oriented by S_band_Ant_b] = S_Band_b.duplicate_around_axis(axis=Z, angle=180deg, total=2)
  L_Band_b_2 [copper, oriented by L_Band_Ant_b] = L_Band_b.duplicate_around_axis(axis=Z, angle=180deg, total=2)
  Snap_Band_Form_b_1 [Astroquartz, oriented by UHF_Ant_a] = Snap_Band_Form_b.duplicate_around_axis(axis=Z, angle=180deg, total=2)
  Port_a_1 = Port_a.duplicate_around_axis(axis=Z, angle=180deg, total=2)
  Port_b_1 = Port_b.duplicate_around_axis(axis=Z, angle=180deg, total=2)
  Layer1 [copper] = box(corner=(-44.8mm, -49.9mm, -10mm-zC*10mm+p*1.641mm), size=(94.7mm, 99.8mm, -0.0356mm))
  cornerCut1 = box(corner=(49.9mm, 49.9mm, -10mm-zC*10mm+p*1.641mm), size=(-8.5mm, -15.5mm, -1.641mm))
  corner1 = box(corner=(41.4mm, 34.4mm, -10mm-zC*10mm+p*1.641mm), size=(4.9mm, 12.75mm, -1.641mm))
  cornerCut1.subtract(corner1)
  cornerCut1_1 = cornerCut1.copy()
  cornerCut1_2 = cornerCut1.copy()
  cornerCut1_3 = cornerCut1.copy()
  cornerCut1_4 = cornerCut1.copy()
  cornerCut2 = box(corner=(49.9mm, -49.9mm, -10mm-zC*10mm+p*1.641mm), size=(-8.5mm, 15.5mm, -1.641mm))
  corner2 = box(corner=(41.4mm, -34.4mm, -10mm-zC*10mm+p*1.641mm), size=(4.9mm, -12.75mm, -1.641mm))
  cornerCut2.subtract(corner2)
  cornerCut2_1 = cornerCut2.copy()
  cornerCut2_2 = cornerCut2.copy()
  cornerCut2_3 = cornerCut2.copy()
  cornerCut2_4 = cornerCut2.copy()
  Layer1.subtract(cornerCut1_4, cornerCut2_4)
  Layer1.chamfer(Edges=Layer1.edge(11 of 12, 9 of 12) LeftDistance=5.8mm RightDistance=5.8mm ChamferType=Symmetric)
  insulator1 [FR4_epoxy] = box(corner=(-44.8mm, -49.9mm, -10.0356mm-zC*10mm+p*1.641mm), size=(94.7mm, 99.8mm, -0.1702mm))
  insulator1.subtract(cornerCut1_1, cornerCut2_1)
  insulator1.chamfer(Edges=insulator1.edge(11 of 12, 9 of 12) LeftDistance=5.8mm RightDistance=5.8mm ChamferType=Symmetric)
  Layer15 [copper] = box(corner=(-44.8mm, -49.9mm, -10.2058mm-zC*10mm+p*1.641mm), size=(94.7mm, 99.8mm, -0.0178mm))
  cornerCut1_5 = cornerCut1.copy()
  cornerCut2_5 = cornerCut2.copy()
  Layer15.subtract(cornerCut1_5, cornerCut2_5)
  Layer15.chamfer(Edges=Layer15.edge(11 of 12, 9 of 12) LeftDistance=5.8mm RightDistance=5.8mm ChamferType=Symmetric)
  insulator2 [FR4_epoxy] = box(corner=(-44.8mm, -49.9mm, -10.2236mm-zC*10mm+p*1.641mm), size=(94.7mm, 99.8mm, -1.1938mm))
  insulator2.subtract(cornerCut1_2, cornerCut2_2)
  insulator2.chamfer(Edges=insulator2.edge(11 of 12, 9 of 12) LeftDistance=5.8mm RightDistance=5.8mm ChamferType=Symmetric)
  Layer16 [copper] = box(corner=(-44.8mm, -49.9mm, -11.4174mm-zC*10mm+p*1.641mm), size=(94.7mm, 99.8mm, -0.0178mm))
  cornerCut1_6 = cornerCut1.copy()
  cornerCut2_6 = cornerCut2.copy()
  Layer16.subtract(cornerCut1_6, cornerCut2_6)
  Layer16.chamfer(Edges=Layer16.edge(11 of 12, 9 of 12) LeftDistance=5.8mm RightDistance=5.8mm ChamferType=Symmetric)
  insulator3 [FR4_epoxy] = box(corner=(-44.8mm, -49.9mm, -11.4352mm-zC*10mm+p*1.641mm), size=(94.7mm, 99.8mm, -0.1702mm))
  insulator3.subtract(cornerCut1_3, cornerCut2_3)
  insulator3.chamfer(Edges=insulator3.edge(11 of 12, 9 of 12) LeftDistance=5.8mm RightDistance=5.8mm ChamferType=Symmetric)
  Layer2 [copper] = box(corner=(-44.8mm, -49.9mm, -11.6054mm-zC*10mm+p*1.641mm), size=(94.7mm, 99.8mm, -0.0356mm))
  Layer2.subtract(cornerCut1, cornerCut2)
  Layer2.chamfer(Edges=Layer2.edge(11 of 12, 9 of 12) LeftDistance=5.8mm RightDistance=5.8mm ChamferType=Symmetric)
boundaries and excitations:
  AutoOpen1: Radiation Objects=RadiatingSurface
  L_Band_a_T1: Terminal port=1 Edges=L_Band_a.edge(at (29.35, 24.81, -9)) TerminalResistance=50ohm
  L_Band_b_T1: Terminal port=2 Edges=L_Band_b.edge(at (-24.81, 29.35, -9)) TerminalResistance=50ohm
  L_Band_a_2_T1: Terminal port=3 Edges=L_Band_a_2.edge(2 of 4) TerminalResistance=50ohm
  L_Band_b_2_T1: Terminal port=4 Edges=L_Band_b_2.edge(2 of 4) TerminalResistance=50ohm
  1: Lumped Port Faces=Port_a.face(#1362) Impedance=50ohm
  2: Lumped Port Faces=Port_b.face(#1375) Impedance=50ohm
  3: Lumped Port Faces=Port_a_1.face Impedance=50ohm
  4: Lumped Port Faces=Port_b_1.face Impedance=50ohm
  reference conductors: Layer1
setups:
  Lband: HfssDriven Frequency=1265MHz MaxDeltaS=0.05 MaximumPasses=30 MinimumPasses=1 MinimumConvergedPasses=1 PercentRefinement=30 BasisOrder=1 PortAccuracy=2 IterativeResidual=1e-06 DDMSolverResidual=0.0001
source amplitudes:
  1:1: 1V 0deg
  2:1, 3:1, 4:1: 0V 0deg
radiation setups:
  3D: Infinite Sphere Theta=0deg..180deg step 2deg Phi=-180deg..180deg step 2deg
  Elevation: Infinite Sphere Theta=-180deg..180deg step 1deg Phi=0deg..90deg step 90deg
  Azimuth: Infinite Sphere Theta=90deg..90deg step 0deg Phi=-180deg..180deg step 1deg
