# Ansys Electronics Desktop project, version 2018.1
materials:
  vacuum: permittivity=1
  copper: permeability=0.999991 conductivity=58000000
  Astroquartz: permittivity=3.72 delta_H_freq=1000000000

design HFSSDesign1 (HFSS, DrivenTerminal, model units mm)
options: open_region{BoundaryType=0 OpFreq=5GHz}
variables:
  Ant_diameter = 2mm
  UHF_len = 172mm
  UHF_x = 30mm
  UHF_y = 29mm
  zPlane = 0mm
  Ant_Phi = 45deg
  Ant_Theta = 0deg
  Ant_lead = 1mm
  Lband_x = -0.65mm
  Lband_y = -4.19mm
  Lband_len = 59mm
  Sband_x = -0.65mm
  Sband_y = 4.19mm
  Sband_len = 31mm
  Snap_width = 18mm
  Snap_radius = -(Lband_x^2+Lband_y^2)/(2*Lband_x) meter
  Snap_angle = Snap_width/Snap_radius rad
  Snap_laminant = 0.5mm
  Snap_len = 200mm
  UHF_len_a = 172mm
  Sband_len_a = 31mm
  Lband_len_a = 59mm
  Lband_len_b = 59mm
  Sband_len_b = 31mm
  UHF_len_b = 172mm
geometry:
  RadiatingSurface [vacuum] = region(absolute_offset=20mm on all sides)
  coordinate_system UHF_Ant_a = origin=(UHF_x, UHF_y, zPlane+Ant_lead) x=(1mm, 0mm, 0mm) y=(0mm, 1mm, 0mm)
  UHF_a [copper, oriented by UHF_Ant_a] = cylinder(axis=Z, base_centre=(0, 0, 0), radius=Ant_diameter/2, height=UHF_len_a) in UHF_Ant_a
  UHF_a.rotate(axis=Y, angle=Ant_Phi) in UHF_Ant_a
  UHF_a.rotate(axis=Z, angle=Ant_Theta) in UHF_Ant_a
  coordinate_system L_Band_Ant_a = origin=(Lband_x, Lband_y, 0mm) x=(1mm, 0mm, 0mm) y=(0mm, 1mm, 0mm) in UHF_Ant_a
  L_Band_a [copper, oriented by L_Band_Ant_a] = cylinder(axis=Z, base_centre=(0, 0, 0), radius=Ant_diameter/2, height=Lband_len_a) in L_Band_Ant_a
  coordinate_system S_Band_Ant_a = origin=(Lband_x, -Lband_y, 0mm) x=(1mm, 0mm, 0mm) y=(0mm, 1mm, 0mm) in UHF_Ant_a
  S_Band_a [copper] = cylinder(axis=Z, base_centre=(0mm, 0mm, 0mm), radius=Ant_diameter/2, height=Sband_len_a) in S_Band_Ant_a
  L_Band_a.rotate(axis=Y, angle=Ant_Phi) in L_Band_Ant_a
  L_Band_a.rotate(axis=Z, angle=Ant_Theta) in UHF_Ant_a
  S_Band_a.rotate(axis=Y, angle=Ant_Phi) in S_Band_Ant_a
  S_Band_a.rotate(axis=Z, angle=Ant_Theta) in UHF_Ant_a
  Snap_Band_Form_a [Astroquartz, oriented by UHF_Ant_a] = equation_based_surface(XuvFunction=-(Snap_radius-(_u*cos(_v))) YuvFunction=-(_u*cos(Ant_Phi)+Snap_radius*(1-cos(Ant_Phi)))*sin(_v) ZuvFunction=0 uStart=Snap_radius-Ant_diameter/(2*cos(Ant_Phi))-Snap_laminant/sin(Ant_Phi) uEnd=Snap_radius+Ant_diameter/(2*cos(Ant_Phi))+Snap_laminant/sin(Ant_Phi) vStart=Snap_angle/2 vEnd=-Snap_angle/2) in UHF_Ant_a
  Snap_Band_Length = polyline((0mm, 0mm, 0mm) (0mm, 0mm, Snap_len)) in UHF_Ant_a
  Snap_Band_Length.rotate(axis=Y, angle=Ant_Phi) in UHF_Ant_a
  Snap_Band_Form_a.sweep_along_path(Snap_Band_Length)
  Snap_Band_Form_a.rotate(axis=Z, angle=Ant_Theta) in UHF_Ant_a
  Antenna_Cut = object_from(Snap_Band_Form_a.face(1 of 1))
  Polyline2 = polyline((0mm, 0mm, 0mm) (0mm, 0mm, -3/5*Ant_diameter*sin(Ant_Phi))) in UHF_Ant_a
  Antenna_Cut.sweep_along_path(Polyline2)
  Antenna_Cut.rotate(axis=Z, angle=Ant_Theta) in UHF_Ant_a
  Ant_Cut_a = Antenna_Cut.copy()
  Antenna_Cut.delete()
  UHF_pin = cylinder(axis=Z, base_centre=(0mm, 0mm, 0mm), radius=Ant_diameter/2, height=-Ant_lead) in UHF_Ant_a
  Lband_pin = cylinder(axis=Z, base_centre=(0mm, 0mm, 0mm), radius=Ant_diameter/2, height=-Ant_lead) in L_Band_Ant_a
  Sband_pin = cylinder(axis=Z, base_centre=(0mm, 0mm, 0mm), radius=Ant_diameter/2, height=-Ant_lead) in S_Band_Ant_a
  [Sband_pin, Lband_pin].rotate(axis=Z, angle=Ant_Theta) in UHF_Ant_a
  coordinate_system UHF_Ant_b = origin=(-UHF_y, UHF_x, zPlane+Ant_lead) x=(1mm, 0mm, 0mm) y=(0mm, 1mm, 0mm)
  coordinate_system L_Band_Ant_b = origin=(-Lband_y, Lband_x, 0mm) x=(1mm, 0mm, 0mm) y=(0mm, 1mm, 0mm) in UHF_Ant_b
  coordinate_system S_band_Ant_b = origin=(Lband_y, Lband_x, 0mm) x=(1mm, 0mm, 0mm) y=(0mm, 1mm, 0mm) in UHF_Ant_b
  UHF_b [copper, oriented by UHF_Ant_b] = cylinder(axis=Z, base_centre=(0mm, 0mm, 0mm), radius=Ant_diameter/2, height=UHF_len_b) in UHF_Ant_b
  S_Band_b [copper, oriented by S_band_Ant_b] = cylinder(axis=Z, base_centre=(0mm, 0mm, 0mm), radius=Ant_diameter/2, height=Sband_len_b) in S_band_Ant_b
  L_Band_b [copper, oriented by L_Band_Ant_b] = cylinder(axis=Z, base_centre=(0mm, 0mm, 0mm), radius=Ant_diameter/2, height=Lband_len_b) in L_Band_Ant_b
  UHF_b.rotate(axis=X, angle=-Ant_Phi) in UHF_Ant_b
  S_Band_b.rotate(axis=X, angle=-Ant_Phi) in S_band_Ant_b
  L_Band_b.rotate(axis=X, angle=-Ant_Phi) in L_Band_Ant_b
  [UHF_b, S_Band_b, L_Band_b].rotate(axis=Z, angle=Ant_Theta) in UHF_Ant_b
  Snap_Band_Form_b [Astroquartz, oriented by UHF_Ant_a] = Snap_Band_Form_a.duplicate_around_axis(axis=Z, angle=90deg, total=2)
  Ant_Cut_b = Ant_Cut_a.duplicate_around_axis(axis=Z, angle=90deg, total=2)
  L_Band_a_1 = L_Band_a.copy()
  S_Band_a_1 = S_Band_a.copy()
  UHF_a_1 = UHF_a.copy()
  Snap_Band_Form_a.subtract(L_Band_a_1, S_Band_a_1, UHF_a_1)
  L_Band_b_1 = L_Band_b.copy()
  S_Band_b_1 = S_Band_b.copy()
  UHF_b_1 = UHF_b.copy()
  Snap_Band_Form_b.subtract(L_Band_b_1, S_Band_b_1, UHF_b_1)
  Lband_pin_1 = Lband_pin.duplicate_around_axis(axis=Z, angle=90deg, total=2)
  Sband_pin_1 = Sband_pin.duplicate_around_axis(axis=Z, angle=90deg, total=2)
  UHF_pin_1 = UHF_pin.duplicate_around_axis(axis=Z, angle=90deg, total=2)
  Ant_Cut_a_1 = Ant_Cut_a.copy()
  L_Band_a.subtract(Ant_Cut_a_1)
  Ant_Cut_a_2 = Ant_Cut_a.copy()
  S_Band_a.subtract(Ant_Cut_a_2)
  UHF_a.subtract(Ant_Cut_a)
  S_Band_a.unite(Sband_pin)
  UHF_a.unite(UHF_pin)
  Ant_Cut_b_1 = Ant_Cut_b.copy()
  L_Band_b.subtract(Ant_Cut_b_1)
  Ant_Cut_b_2 = Ant_Cut_b.copy()
  S_Band_b.subtract(Ant_Cut_b_2)
  UHF_b.subtract(Ant_Cut_b)
  S_Band_b.unite(Sband_pin_1)
  UHF_b.unite(UHF_pin_1)
  Port_a = rectangle(corner=(0mm, Ant_diameter/2, 0), y_size=-Ant_diameter, z_size=-Ant_lead) in UHF_Ant_a
  Port_a.rotate(axis=Z, angle=Ant_Theta) in UHF_Ant_a
  Port_b = rectangle(corner=(Ant_diameter/2, 0mm, 0mm), z_size=-Ant_lead, x_size=-Ant_diameter) in UHF_Ant_b
  Port_b.rotate(axis=Z, angle=Ant_Theta) in UHF_Ant_b
  L_Band_a.unite(Lband_pin)
  L_Band_b.unite(Lband_pin_1)
boundaries and excitations:
  AutoOpen1: Radiation Objects=RadiatingSurface
setups:
  Auto1: HfssDriven Frequency=5GHz MaxDeltaE=0.1 MaximumPasses=6 MinimumPasses=1 MinimumConvergedPasses=1 PercentRefinement=30 BasisOrder=1
radiation setups:
  3D: Infinite Sphere Theta=0deg..180deg step 2deg Phi=-180deg..180deg step 2deg
  Elevation: Infinite Sphere Theta=-180deg..180deg step 1deg Phi=0deg..90deg step 90deg
  Azimuth: Infinite Sphere Theta=90deg..90deg step 0deg Phi=-180deg..180deg step 1deg
