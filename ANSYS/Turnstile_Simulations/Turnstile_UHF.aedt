# Ansys Electronics Desktop project, version 2018.1
materials:
  vacuum: permittivity=1
  copper: permeability=0.999991 conductivity=58000000
  Astroquartz: permittivity=3.72 delta_H_freq=1000000000

design HFSSDesign1 (HFSS, DrivenTerminal, model units mm)
options: open_region{BoundaryType=0 OpFreq=5GHz}
variables:
  Ant_diameter = 2mm
  UHF_len = 172mm
  UHF_x = 30.13mm
  UHF_y = 27.34mm
  zPlane = -10mm
  Ant_Phi = 45deg
  Ant_Theta = 0deg
  Ant_lead = 1mm
  Lband_x = -0.65mm
  Lband_y = -4.19mm
  Lband_len = 59mm
  Sband_x = -0.65mm
  Sband_y = 4.19mm
  Sband_len = 31mm
  Snap_width = 18mm
  Snap_radius = -(Lband_x^2+Lband_y^2)/(2*Lband_x) meter
  Snap_angle = Snap_width/Snap_radius rad
  Snap_laminant = 0.5mm
geometry:
  RadiatingSurface [vacuum] = region(absolute_offset=20mm on all sides)
  coordinate_system UHF_Ant = origin=(UHF_x, UHF_y, zPlane+Ant_lead) x=(1mm, 0mm, 0mm) y=(0mm, 1mm, 0mm)
  UHF [copper, oriented by UHF_Ant] = cylinder(axis=Z, base_centre=(0, 0, 0), radius=Ant_diameter/2, height=UHF_len) in UHF_Ant
  UHF.rotate(axis=Y, angle=Ant_Phi) in UHF_Ant
  UHF.rotate(axis=Z, angle=Ant_Theta) in UHF_Ant
  coordinate_system L_Band_Ant = origin=(Lband_x, Lband_y, 0mm) x=(1mm, 0mm, 0mm) y=(0mm, 1mm, 0mm) in UHF_Ant
  L_Band [copper, oriented by L_Band_Ant] = cylinder(axis=Z, base_centre=(0, 0, 0), radius=Ant_diameter/2, height=Lband_len) in L_Band_Ant
  coordinate_system S_Band_Ant = origin=(Sband_x, Sband_y, 0mm) x=(1mm, 0mm, 0mm) y=(0mm, 1mm, 0mm) in UHF_Ant
  S_Band [copper] = cylinder(axis=Z, base_centre=(0mm, 0mm, 0mm), radius=Ant_diameter/2, height=Sband_len) in S_Band_Ant
  L_Band.rotate(axis=Y, angle=Ant_Phi) in L_Band_Ant
  L_Band.rotate(axis=Z, angle=Ant_Theta) in UHF_Ant
  S_Band.rotate(axis=Y, angle=Ant_Phi) in S_Band_Ant
  S_Band.rotate(axis=Z, angle=Ant_Theta) in UHF_Ant
  Polyline1 = polyline(z=0mm, xy: (-Snap_radius*(1-cos(Snap_angle/2)), -Snap_radius*(sin(Snap_angle/2))) (0mm, 0mm) (-2.8265771mm, 8.3780574mm), AngularArc from point 0 over 3 centre=(-Snap_radius, 0mm, 0mm) angle=Snap_angle plane=XY) in UHF_Ant
  Snap_Band_Form [Astroquartz, oriented by UHF_Ant] = equation_based_surface(XuvFunction=-(Snap_radius-(_u*cos(_v))) YuvFunction=-(_u*cos(Ant_Phi)+Snap_radius*(1-cos(Ant_Phi)))*sin(_v) ZuvFunction=0 uStart=Snap_radius-Ant_diameter/(2*cos(Ant_Phi))-Snap_laminant/sin(Ant_Phi) uEnd=Snap_radius+Ant_diameter/(2*cos(Ant_Phi))+Snap_laminant/sin(Ant_Phi) vStart=Snap_angle/2 vEnd=-Snap_angle/2) in UHF_Ant
  Snap_Band_Length = polyline((0mm, 0mm, 0mm) (0mm, 0mm, 200mm)) in UHF_Ant
  Snap_Band_Length.rotate(axis=Y, angle=Ant_Phi) in UHF_Ant
  Snap_Band_Form.sweep_along_path(Snap_Band_Length)
  Snap_Band_Form.rotate(axis=Z, angle=Ant_Theta) in UHF_Ant
  Antenna_Cut = object_from(Snap_Band_Form.face(1 of 1))
  Polyline2 = polyline((0mm, 0mm, 0mm) (0mm, 0mm, -3/5*Ant_diameter*sin(Ant_Phi))) in UHF_Ant
  Antenna_Cut.sweep_along_path(Polyline2)
  Antenna_Cut.rotate(axis=Z, angle=Ant_Theta) in UHF_Ant
  Antenna_Cut_1 = Antenna_Cut.copy()
  L_Band.subtract(Antenna_Cut_1)
  Antenna_Cut_2 = Antenna_Cut.copy()
  S_Band.subtract(Antenna_Cut_2)
  UHF.subtract(Antenna_Cut)
  L_Band_1 = L_Band.copy()
  S_Band_1 = S_Band.copy()
  UHF_1 = UHF.copy()
  Snap_Band_Form.subtract(L_Band_1, S_Band_1, UHF_1)
  Lband_pin = cylinder(axis=Z, base_centre=(0mm, 0mm, 0mm), radius=Ant_diameter/2, height=-Ant_lead) in L_Band_Ant
  Sband_pin = cylinder(axis=Z, base_centre=(0mm, 0mm, 0mm), radius=Ant_diameter/2, height=-Ant_lead) in S_Band_Ant
  [Sband_pin, Lband_pin].rotate(axis=Z, angle=Ant_Theta) in UHF_Ant
  UHF_pin = rectangle(corner=(0mm, Ant_diameter/2, 0mm), y_size=-Ant_diameter, z_size=-Ant_lead) in UHF_Ant
  UHF_pin.rotate(axis=Z, angle=Ant_Theta) in UHF_Ant
  L_Band.unite(Lband_pin)
  S_Band.unite(Sband_pin)
boundaries and excitations:
  AutoOpen1: Radiation Objects=RadiatingSurface
setups:
  Auto1: HfssDriven Frequency=5GHz MaxDeltaE=0.1 MaximumPasses=6 MinimumPasses=1 MinimumConvergedPasses=1 PercentRefinement=30 BasisOrder=1
radiation setups:
  3D: Infinite Sphere Theta=0deg..180deg step 2deg Phi=-180deg..180deg step 2deg
  Elevation: Infinite Sphere Theta=-180deg..180deg step 1deg Phi=0deg..90deg step 90deg
  Azimuth: Infinite Sphere Theta=90deg..90deg step 0deg Phi=-180deg..180deg step 1deg
